*** SPICE deck for cell inverter_sim{sch} from library inv
*** Created on Sun Nov 01, 2026 10:45:13
*** Last revised on Sun Nov 01, 2026 10:49:38
*** Written on Sun Nov 01, 2026 11:05:58 by Electric VLSI Design System, version 9.08
*** Layout tech: mocmos, foundry MOSIS
*** UC SPICE *** , MIN_RESIST 4.0, MIN_CAPAC 0.1FF

*** SUBCIRCUIT inv__inverter FROM CELL inverter{sch}
.SUBCKT inv__inverter gnd in out vdd
** GLOBAL gnd
** GLOBAL vdd
MNMOS out in gnd gnd N L=0.4U W=2U
MPMOS vdd in out vdd P L=0.4U W=4U
.ENDS inv__inverter

.global gnd vdd

*** TOP LEVEL CELL: inverter_sim{sch}
Xinverter@0 gnd in out vdd inv__inverter

* Spice Code nodes in cell cell 'inverter_sim{sch}'
vdd vdd 0 dc 1.2
vin in 0 pulse (0 1.8 0 in 10n 20n)
.tran in 100n
.include C:\Users\SOLEHA\Downloads\electric-vlsi\TSMC_SCN025Parameters.txt
.END
